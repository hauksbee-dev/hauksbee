opamp subckt gain block driving an rc low-pass
.subckt AMP inp out gain=4
Rin inp mid 1
E1 out 0 mid 0 {gain}
.ends
V1 in 0 SIN(0 0.5 1k)
R1 in a 1k
R2 a 0 1k
X1 a x AMP gain=4
RF x out 1k
CF out 0 100n
.tran 5u 2m
.print tran v(out)
.options reltol=1e-4
.end
