MOS body diode: reverse conduction and synchronous takeover (dev-plan 04 s3.3)
* NMOS with bulk tied to the grounded source; a 100 mA sink pulls the drain
* BELOW ground. Gate OFF: the drain clamps one body-diode drop below the
* bulk (the reverse-conduction path every synchronous-rectifier / flyback
* deck depends on). Gate ON: the channel takes over and the drain rises to
* -I*Rds(on) -- synchronous rectification. IS on the card activates the
* body diode (hauksbee deliberately defaults it OFF for bit-identity with
* pre-s3.3 decks; ngspice defaults IS=1e-14, so the card states it
* explicitly to keep both simulators on the same physics). CBD adds the
* drain-bulk depletion charge across the transition.
VG g 0 PULSE(0 5 2u 100n 100n 4u 10u)
I1 d 0 DC 0.1
M1 d g 0 0 MRECT
.model MRECT NMOS(VTO=2 KP=0.1 W=100u L=10u IS=1e-12 CBD=50p)
.tran 10n 8u
.print tran v(d)
.end
