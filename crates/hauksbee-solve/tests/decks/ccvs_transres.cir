ccvs transresistance stage into rc lowpass
V1 in 0 SIN(0 0.5 1k)
R1 in s 2k
VS s 0 0
H1 x 0 VS 3k
RF x out 1k
CF out 0 100n
.tran 5u 2m
.print tran v(out)
.options reltol=1e-4
.end
