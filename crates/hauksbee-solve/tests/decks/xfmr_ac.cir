* Transformer small-signal (SPICE-compat step 11): the jwM cross terms in .ac.
* Magnitude AND phase of the secondary across four decades — low end shows the
* inductive rolloff (secondary EMF falls with w), midband the loaded ratio.
Vin in 0 AC 1
R1 in pri 50
L1 pri 0 1m
L2 sec 0 4m
K1 L1 L2 0.999
RL sec 0 1k
.ac dec 10 100 1e6
.print ac V(sec)
.end
