Ground-referenced adjustable LDO as the primitives the binder stamps
* The error amplifier holds V(fb) - V(gnd) at VREF: VREF from OUT to a private
* node a unity VCVS holds V(out) - V(fb) above ground, a CCCS carrying that
* branch current from IN into ground (the pass element), and IQ from IN to
* ground. R1 = 31.25k on OUT-FB over R2 = 10k on FB-GND puts the rail at
* 0.8*(1 + 31.25k/10k) = 3.3 V; the LM317 law would read 0.8*(1 + 10k/31.25k).
* The expect file's reltol is 2e-8, not 1e-9: gmin (1e-12 S) on the 7.6k FB
* node alone moves VO by 7.6e-9.
VIN in 0 DC 5
VREF out drv DC 0.8
E1 drv 0 out fb 1
F1 in 0 VREF -1
IQ in 0 DC 50u
R1 out fb 31.25k
R2 fb 0 10k
RL out 0 33
.op
.end
