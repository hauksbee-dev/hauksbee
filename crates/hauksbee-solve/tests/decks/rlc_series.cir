rlc series underdamped
V1 in 0 PULSE(0 1 0 1n 1n 1 1)
R1 in a 10
L1 a out 1m
C1 out 0 1u
.tran 1u 800u uic
.print tran v(out)
.options reltol=1e-4
.end
