rc lowpass step
V1 in 0 PULSE(0 5 0 1n 1n 1 1)
R1 in out 1k
C1 out 0 100n
.tran 2u 500u uic
.print tran v(out)
.options reltol=1e-4
.end
