.title KiCad schematic
.include "models/2n2222.model"
.ac dec 100 10 1Meg
C3 Net-_C3-Pad1_ GND 10n
R12 Net-_L2-Pad1_ Net-_Q1-E_ 100
R7 Net-_C3-Pad1_ Net-_L2-Pad1_ 22k
L2 Net-_L2-Pad1_ Net-_C3-Pad1_ 100m
R11 Net-_Q3-B_ GND 10k
R10 Net-_Q2-E_ GND 470
R8 Net-_Q1-E_ GND 2.2k
Q3 /VBASE Net-_Q3-B_ Net-_Q2-E_ Q2N2222
R6 +12V Net-_Q3-B_ 22k
R5 +12V /VBASE 1k
C2 /VBASE GND 220p
Q1 VOUT /VBASE Net-_Q1-E_ Q2N2222
Q2 Net-_Q2-C_ /VIN Net-_Q2-E_ Q2N2222
V3 +12V GND DC 12
R9 /VIN GND 10k
R3 +12V /VIN 22k
R4 +12V Net-_Q2-C_ 1k
C1 /VIN Net-_C1-Pad2_ 1U
V1 Net-_C1-Pad2_ GND DC 0 SIN( 0 1 1k 0 0 0 ) AC 1
L1 Net-_C4-Pad2_ VOUT 100m
R2 VOUT Net-_C4-Pad2_ 22k
R1 +12V Net-_C4-Pad2_ 10
C4 VOUT Net-_C4-Pad2_ 10n
.end
